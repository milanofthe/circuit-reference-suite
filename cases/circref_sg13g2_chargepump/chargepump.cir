Four-stage Dickson charge pump, IHP SG13G2 high-voltage MOS
* Diode-connected 3.3 V NMOS, 1 pF pump capacitors on two complementary 20 MHz clocks,
* 10 pF and 2 MOhm at the output: clock edges of 1 ns against a settling time of
* microseconds.
.lib "ngspice/models/cornerMOShv.lib" mos_tt
vdd vdd 0 dc 3.3
vclk clk 0 dc 0 pulse(0 3.3 5n 1n 1n 23n 50n)
vclkb clkb 0 dc 3.3 pulse(3.3 0 5n 1n 1n 23n 50n)
xm1 vdd vdd n1 0 sg13_hv_nmos w=10u l=0.45u
xm2 n1 n1 n2 0 sg13_hv_nmos w=10u l=0.45u
xm3 n2 n2 n3 0 sg13_hv_nmos w=10u l=0.45u
xm4 n3 n3 n4 0 sg13_hv_nmos w=10u l=0.45u
xm5 n4 n4 out 0 sg13_hv_nmos w=10u l=0.45u
c1 n1 clk 1p
c2 n2 clkb 1p
c3 n3 clk 1p
c4 n4 clkb 1p
cout out 0 10p
rload out 0 2meg
.save v(clk) v(n1) v(n2) v(n4) v(out)
.op
.tran 0.5n 10u
.end
